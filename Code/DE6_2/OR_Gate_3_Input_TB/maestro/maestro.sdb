ADE simulation setup
Run mode: Single Run, Sweeps and Corners
Tests:
  Test_DE6_2_OR_Gate_3_Input_TB_1: Test_DE6_2/OR_Gate_3_Input_TB/schematic, simulator spectre
