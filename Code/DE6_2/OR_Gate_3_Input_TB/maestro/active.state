ADE simulation setup
Test Test_DE6_2_OR_Gate_3_Input_TB_1: Test_DE6_2/OR_Gate_3_Input_TB/schematic, simulator spectre
  Models: /network/rit/home/ss819183/cadence/TechLibs/gpdk045_v_6_0/gpdk045//../models/spectre/gpdk045.scs[tt]
  Temperature: 27
  Analysis tran: stop=64n errpreset=conservative
  Signals: /net2, /net3, /net4, /net1, /C0/PLUS (terminal), /C0/MINUS (terminal)
Run mode: Single Run, Sweeps and Corners
